// Spectre isource PWL for I_NEURON_299
I_NEURON_299 (iin 0) isource type=pwl wave=[ 0.000000000000e+00 1.557157020216e-06 4.999000000000e-06 1.557157020216e-06 5.000000000000e-06 1.365658363284e-06 9.999000000000e-06 1.365658363284e-06 1.000000000000e-05 1.168637140836e-06 1.499900000000e-05 1.168637140836e-06 1.500000000000e-05 8.898330747797e-07 1.999900000000e-05 8.898330747797e-07 2.000000000000e-05 1.128453163801e-06 2.499900000000e-05 1.128453163801e-06 2.500000000000e-05 1.257957137568e-06 2.999900000000e-05 1.257957137568e-06 3.000000000000e-05 1.534203079245e-06 3.499900000000e-05 1.534203079245e-06 3.500000000000e-05 1.150916432380e-06 3.999900000000e-05 1.150916432380e-06 4.000000000000e-05 1.304724037254e-06 4.499900000000e-05 1.304724037254e-06 4.500000000000e-05 1.711116738079e-06 4.999900000000e-05 1.711116738079e-06 5.000000000000e-05 1.172423139906e-06 5.499900000000e-05 1.172423139906e-06 5.500000000000e-05 1.042270810103e-06 5.999900000000e-05 1.042270810103e-06 6.000000000000e-05 1.097126755667e-06 6.499900000000e-05 1.097126755667e-06 6.500000000000e-05 1.291338662668e-06 6.999900000000e-05 1.291338662668e-06 7.000000000000e-05 1.242650455424e-06 7.499900000000e-05 1.242650455424e-06 7.500000000000e-05 1.270717461921e-06 7.999900000000e-05 1.270717461921e-06 8.000000000000e-05 1.746130237734e-06 8.499900000000e-05 1.746130237734e-06 8.500000000000e-05 1.186361714645e-06 8.999900000000e-05 1.186361714645e-06 9.000000000000e-05 1.209350784848e-06 9.499900000000e-05 1.209350784848e-06 9.500000000000e-05 1.351226501356e-06 9.999900000000e-05 1.351226501356e-06 1.000000000000e-04 1.351226501356e-06 ]
