// Spectre isource PWL for I_NEURON_78
I_NEURON_78 (iin 0) isource type=pwl wave=[ 0.000000000000e+00 4.176713900961e-06 4.999000000000e-06 4.176713900961e-06 5.000000000000e-06 3.752964857995e-06 9.999000000000e-06 3.752964857995e-06 1.000000000000e-05 4.771666226588e-06 1.499900000000e-05 4.771666226588e-06 1.500000000000e-05 4.167941824562e-06 1.999900000000e-05 4.167941824562e-06 2.000000000000e-05 4.216645265842e-06 2.499900000000e-05 4.216645265842e-06 2.500000000000e-05 3.947440745833e-06 2.999900000000e-05 3.947440745833e-06 3.000000000000e-05 4.314150373830e-06 3.499900000000e-05 4.314150373830e-06 3.500000000000e-05 3.810772568613e-06 3.999900000000e-05 3.810772568613e-06 4.000000000000e-05 4.077289304405e-06 4.499900000000e-05 4.077289304405e-06 4.500000000000e-05 3.961962647736e-06 4.999900000000e-05 3.961962647736e-06 5.000000000000e-05 4.165277005086e-06 5.499900000000e-05 4.165277005086e-06 5.500000000000e-05 4.699839337263e-06 5.999900000000e-05 4.699839337263e-06 6.000000000000e-05 4.102180355403e-06 6.499900000000e-05 4.102180355403e-06 6.500000000000e-05 4.551759047899e-06 6.999900000000e-05 4.551759047899e-06 7.000000000000e-05 4.723715846922e-06 7.499900000000e-05 4.723715846922e-06 7.500000000000e-05 4.092914878129e-06 7.999900000000e-05 4.092914878129e-06 8.000000000000e-05 4.282946065359e-06 8.499900000000e-05 4.282946065359e-06 8.500000000000e-05 4.352617906989e-06 8.999900000000e-05 4.352617906989e-06 9.000000000000e-05 3.955194642913e-06 9.499900000000e-05 3.955194642913e-06 9.500000000000e-05 3.979181656177e-06 9.999900000000e-05 3.979181656177e-06 1.000000000000e-04 3.979181656177e-06 ]
