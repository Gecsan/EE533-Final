// Spectre isource PWL for I_NEURON_152
I_NEURON_152 (iin 0) isource type=pwl wave=[ 0.000000000000e+00 4.124256065552e-06 4.999000000000e-06 4.124256065552e-06 5.000000000000e-06 4.049062681588e-06 9.999000000000e-06 4.049062681588e-06 1.000000000000e-05 4.093551069673e-06 1.499900000000e-05 4.093551069673e-06 1.500000000000e-05 4.582965630107e-06 1.999900000000e-05 4.582965630107e-06 2.000000000000e-05 4.132135018153e-06 2.499900000000e-05 4.132135018153e-06 2.500000000000e-05 4.660861577577e-06 2.999900000000e-05 4.660861577577e-06 3.000000000000e-05 4.283720500098e-06 3.499900000000e-05 4.283720500098e-06 3.500000000000e-05 3.904632649210e-06 3.999900000000e-05 3.904632649210e-06 4.000000000000e-05 4.584369435179e-06 4.499900000000e-05 4.584369435179e-06 4.500000000000e-05 4.133486527280e-06 4.999900000000e-05 4.133486527280e-06 5.000000000000e-05 3.958570232498e-06 5.499900000000e-05 3.958570232498e-06 5.500000000000e-05 4.614625140675e-06 5.999900000000e-05 4.614625140675e-06 6.000000000000e-05 4.301828539610e-06 6.499900000000e-05 4.301828539610e-06 6.500000000000e-05 4.230396825733e-06 6.999900000000e-05 4.230396825733e-06 7.000000000000e-05 4.935400738759e-06 7.499900000000e-05 4.935400738759e-06 7.500000000000e-05 4.564862592815e-06 7.999900000000e-05 4.564862592815e-06 8.000000000000e-05 4.783979420608e-06 8.499900000000e-05 4.783979420608e-06 8.500000000000e-05 4.398065357236e-06 8.999900000000e-05 4.398065357236e-06 9.000000000000e-05 3.293761210443e-06 9.499900000000e-05 3.293761210443e-06 9.500000000000e-05 4.323299890530e-06 9.999900000000e-05 4.323299890530e-06 1.000000000000e-04 4.323299890530e-06 ]
