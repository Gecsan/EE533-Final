// Spectre isource PWL for I_NEURON_97
I_NEURON_97 (iin 0) isource type=pwl wave=[ 0.000000000000e+00 1.496103664067e-06 4.999000000000e-06 1.496103664067e-06 5.000000000000e-06 1.447262434340e-06 9.999000000000e-06 1.447262434340e-06 1.000000000000e-05 1.464690285502e-06 1.499900000000e-05 1.464690285502e-06 1.500000000000e-05 1.942272547240e-06 1.999900000000e-05 1.942272547240e-06 2.000000000000e-05 1.241492554982e-06 2.499900000000e-05 1.241492554982e-06 2.500000000000e-05 1.303112071582e-06 2.999900000000e-05 1.303112071582e-06 3.000000000000e-05 1.103764248001e-06 3.499900000000e-05 1.103764248001e-06 3.500000000000e-05 1.176351474896e-06 3.999900000000e-05 1.176351474896e-06 4.000000000000e-05 1.370446625515e-06 4.499900000000e-05 1.370446625515e-06 4.500000000000e-05 1.201365307679e-06 4.999900000000e-05 1.201365307679e-06 5.000000000000e-05 1.393702746100e-06 5.499900000000e-05 1.393702746100e-06 5.500000000000e-05 1.085711119231e-06 5.999900000000e-05 1.085711119231e-06 6.000000000000e-05 1.383129301757e-06 6.499900000000e-05 1.383129301757e-06 6.500000000000e-05 1.166119773188e-06 6.999900000000e-05 1.166119773188e-06 7.000000000000e-05 1.127159862335e-06 7.499900000000e-05 1.127159862335e-06 7.500000000000e-05 1.327037807641e-06 7.999900000000e-05 1.327037807641e-06 8.000000000000e-05 9.742567499416e-07 8.499900000000e-05 9.742567499416e-07 8.500000000000e-05 1.437526066184e-06 8.999900000000e-05 1.437526066184e-06 9.000000000000e-05 1.415214228473e-06 9.499900000000e-05 1.415214228473e-06 9.500000000000e-05 1.236249772774e-06 9.999900000000e-05 1.236249772774e-06 1.000000000000e-04 1.236249772774e-06 ]
