// Spectre isource PWL for I_NEURON_245
I_NEURON_245 (iin 0) isource type=pwl wave=[ 0.000000000000e+00 4.494408130995e-06 4.999000000000e-06 4.494408130995e-06 5.000000000000e-06 3.735563950613e-06 9.999000000000e-06 3.735563950613e-06 1.000000000000e-05 4.224686108500e-06 1.499900000000e-05 4.224686108500e-06 1.500000000000e-05 4.151838766120e-06 1.999900000000e-05 4.151838766120e-06 2.000000000000e-05 3.968229066231e-06 2.499900000000e-05 3.968229066231e-06 2.500000000000e-05 4.111820544495e-06 2.999900000000e-05 4.111820544495e-06 3.000000000000e-05 4.559662102110e-06 3.499900000000e-05 4.559662102110e-06 3.500000000000e-05 4.295088729123e-06 3.999900000000e-05 4.295088729123e-06 4.000000000000e-05 3.931963419745e-06 4.499900000000e-05 3.931963419745e-06 4.500000000000e-05 3.902548542101e-06 4.999900000000e-05 3.902548542101e-06 5.000000000000e-05 3.683161367007e-06 5.499900000000e-05 3.683161367007e-06 5.500000000000e-05 4.462948709261e-06 5.999900000000e-05 4.462948709261e-06 6.000000000000e-05 3.695132136272e-06 6.499900000000e-05 3.695132136272e-06 6.500000000000e-05 4.211930445308e-06 6.999900000000e-05 4.211930445308e-06 7.000000000000e-05 4.492142124946e-06 7.499900000000e-05 4.492142124946e-06 7.500000000000e-05 3.820248366537e-06 7.999900000000e-05 3.820248366537e-06 8.000000000000e-05 4.287660431146e-06 8.499900000000e-05 4.287660431146e-06 8.500000000000e-05 4.740751137433e-06 8.999900000000e-05 4.740751137433e-06 9.000000000000e-05 3.527275339366e-06 9.499900000000e-05 3.527275339366e-06 9.500000000000e-05 3.771460796997e-06 9.999900000000e-05 3.771460796997e-06 1.000000000000e-04 3.771460796997e-06 ]
