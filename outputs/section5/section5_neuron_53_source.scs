// Spectre isource PWL for I_NEURON_53
I_NEURON_53 (iin 0) isource type=pwl wave=[ 0.000000000000e+00 8.419538630733e-07 4.999000000000e-06 8.419538630733e-07 5.000000000000e-06 1.127889731833e-06 9.999000000000e-06 1.127889731833e-06 1.000000000000e-05 1.174414592242e-06 1.499900000000e-05 1.174414592242e-06 1.500000000000e-05 1.356567850053e-06 1.999900000000e-05 1.356567850053e-06 2.000000000000e-05 1.282164475924e-06 2.499900000000e-05 1.282164475924e-06 2.500000000000e-05 7.122196166165e-07 2.999900000000e-05 7.122196166165e-07 3.000000000000e-05 1.157383280770e-06 3.499900000000e-05 1.157383280770e-06 3.500000000000e-05 9.997927463701e-07 3.999900000000e-05 9.997927463701e-07 4.000000000000e-05 1.172802853944e-06 4.499900000000e-05 1.172802853944e-06 4.500000000000e-05 1.045826934387e-06 4.999900000000e-05 1.045826934387e-06 5.000000000000e-05 8.678366043569e-07 5.499900000000e-05 8.678366043569e-07 5.500000000000e-05 1.038016307575e-06 5.999900000000e-05 1.038016307575e-06 6.000000000000e-05 9.739352435645e-07 6.499900000000e-05 9.739352435645e-07 6.500000000000e-05 1.114499355026e-06 6.999900000000e-05 1.114499355026e-06 7.000000000000e-05 1.010128357848e-06 7.499900000000e-05 1.010128357848e-06 7.500000000000e-05 1.062298792931e-06 7.999900000000e-05 1.062298792931e-06 8.000000000000e-05 9.132122613664e-07 8.499900000000e-05 9.132122613664e-07 8.500000000000e-05 1.113015855481e-06 8.999900000000e-05 1.113015855481e-06 9.000000000000e-05 1.371633402414e-06 9.499900000000e-05 1.371633402414e-06 9.500000000000e-05 1.219626369675e-06 9.999900000000e-05 1.219626369675e-06 1.000000000000e-04 1.219626369675e-06 ]
