// Spectre isource PWL for I_NEURON_36
I_NEURON_36 (iin 0) isource type=pwl wave=[ 0.000000000000e+00 4.135659310123e-06 4.999000000000e-06 4.135659310123e-06 5.000000000000e-06 3.675384050439e-06 9.999000000000e-06 3.675384050439e-06 1.000000000000e-05 4.948989499098e-06 1.499900000000e-05 4.948989499098e-06 1.500000000000e-05 3.828856733890e-06 1.999900000000e-05 3.828856733890e-06 2.000000000000e-05 4.268930297258e-06 2.499900000000e-05 4.268930297258e-06 2.500000000000e-05 3.845598712360e-06 2.999900000000e-05 3.845598712360e-06 3.000000000000e-05 4.700919816969e-06 3.499900000000e-05 4.700919816969e-06 3.500000000000e-05 3.648539632195e-06 3.999900000000e-05 3.648539632195e-06 4.000000000000e-05 4.152171186433e-06 4.499900000000e-05 4.152171186433e-06 4.500000000000e-05 4.336557594797e-06 4.999900000000e-05 4.336557594797e-06 5.000000000000e-05 3.645200877145e-06 5.499900000000e-05 3.645200877145e-06 5.500000000000e-05 4.728776730190e-06 5.999900000000e-05 4.728776730190e-06 6.000000000000e-05 4.115735919186e-06 6.499900000000e-05 4.115735919186e-06 6.500000000000e-05 5.043832516094e-06 6.999900000000e-05 5.043832516094e-06 7.000000000000e-05 4.060877017764e-06 7.499900000000e-05 4.060877017764e-06 7.500000000000e-05 3.777233359870e-06 7.999900000000e-05 3.777233359870e-06 8.000000000000e-05 4.131516561756e-06 8.499900000000e-05 4.131516561756e-06 8.500000000000e-05 4.324025212554e-06 8.999900000000e-05 4.324025212554e-06 9.000000000000e-05 3.796396867983e-06 9.499900000000e-05 3.796396867983e-06 9.500000000000e-05 3.919126356777e-06 9.999900000000e-05 3.919126356777e-06 1.000000000000e-04 3.919126356777e-06 ]
