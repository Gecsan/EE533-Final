// Scaled Spectre isource PWL for I_NEURON_36_SCALED
I_NEURON_36_SCALED (iin 0) isource type=pwl wave=[ 0.000000000000e+00 3.982132008235e-09 4.999000000000e-06 3.982132008235e-09 5.000000000000e-06 3.538943460353e-09 9.999000000000e-06 3.538943460353e-09 1.000000000000e-05 4.765269093742e-09 1.499900000000e-05 4.765269093742e-09 1.500000000000e-05 3.686718806273e-09 1.999900000000e-05 3.686718806273e-09 2.000000000000e-05 4.110455601607e-09 2.499900000000e-05 4.110455601607e-09 2.500000000000e-05 3.702839275429e-09 2.999900000000e-05 3.702839275429e-09 3.000000000000e-05 4.526408455715e-09 3.499900000000e-05 4.526408455715e-09 3.500000000000e-05 3.513095582393e-09 3.999900000000e-05 3.513095582393e-09 4.000000000000e-05 3.998030917269e-09 4.499900000000e-05 3.998030917269e-09 4.500000000000e-05 4.175572383713e-09 4.999900000000e-05 4.175572383713e-09 5.000000000000e-05 3.509880771318e-09 5.499900000000e-05 3.509880771318e-09 5.500000000000e-05 4.553231241992e-09 5.999900000000e-05 4.553231241992e-09 6.000000000000e-05 3.962948229588e-09 6.499900000000e-05 3.962948229588e-09 6.500000000000e-05 4.856591271276e-09 6.999900000000e-05 4.856591271276e-09 7.000000000000e-05 3.910125844835e-09 7.499900000000e-05 3.910125844835e-09 7.500000000000e-05 3.637011837047e-09 7.999900000000e-05 3.637011837047e-09 8.000000000000e-05 3.978143050335e-09 8.499900000000e-05 3.978143050335e-09 8.500000000000e-05 4.163505238736e-09 8.999900000000e-05 4.163505238736e-09 9.000000000000e-05 3.655463941856e-09 9.499900000000e-05 3.655463941856e-09 9.500000000000e-05 3.773637366946e-09 9.999900000000e-05 3.773637366946e-09 1.000000000000e-04 3.773637366946e-09 ]
