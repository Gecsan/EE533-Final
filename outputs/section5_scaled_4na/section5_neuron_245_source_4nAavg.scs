// Scaled Spectre isource PWL for I_NEURON_245_SCALED
I_NEURON_245_SCALED (iin 0) isource type=pwl wave=[ 0.000000000000e+00 4.381127119874e-09 4.999000000000e-06 4.381127119874e-09 5.000000000000e-06 3.641409514901e-09 9.999000000000e-06 3.641409514901e-09 1.000000000000e-05 4.118203408200e-09 1.499900000000e-05 4.118203408200e-09 1.500000000000e-05 4.047192174238e-09 1.999900000000e-05 4.047192174238e-09 2.000000000000e-05 3.868210334536e-09 2.499900000000e-05 3.868210334536e-09 2.500000000000e-05 4.008182607029e-09 2.999900000000e-05 4.008182607029e-09 3.000000000000e-05 4.444736372572e-09 3.499900000000e-05 4.444736372572e-09 3.500000000000e-05 4.186831539320e-09 3.999900000000e-05 4.186831539320e-09 4.000000000000e-05 3.832858759266e-09 4.499900000000e-05 3.832858759266e-09 4.500000000000e-05 3.804185280040e-09 4.999900000000e-05 3.804185280040e-09 5.000000000000e-05 3.590327732051e-09 5.499900000000e-05 3.590327732051e-09 5.500000000000e-05 4.350460629045e-09 5.999900000000e-05 4.350460629045e-09 6.000000000000e-05 3.601996779531e-09 6.499900000000e-05 3.601996779531e-09 6.500000000000e-05 4.105769249950e-09 6.999900000000e-05 4.105769249950e-09 7.000000000000e-05 4.378918228233e-09 7.499900000000e-05 4.378918228233e-09 7.500000000000e-05 3.723959470407e-09 7.999900000000e-05 3.723959470407e-09 8.000000000000e-05 4.179590470692e-09 8.499900000000e-05 4.179590470692e-09 8.500000000000e-05 4.621261080752e-09 8.999900000000e-05 4.621261080752e-09 9.000000000000e-05 3.438370792805e-09 9.499900000000e-05 3.438370792805e-09 9.500000000000e-05 3.676401585632e-09 9.999900000000e-05 3.676401585632e-09 1.000000000000e-04 3.676401585632e-09 ]
