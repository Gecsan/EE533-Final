// 500 ms hold-current Spectre isource PWL for I_NEURON_152_500MS
I_NEURON_152_500MS (iin 0) isource type=pwl wave=[ 0.000000000000e+00 3.838578275969e-09 4.999000000000e-06 3.838578275969e-09 5.000000000000e-06 3.768593365820e-09 9.999000000000e-06 3.768593365820e-09 1.000000000000e-05 3.810000144963e-09 1.499900000000e-05 3.810000144963e-09 1.500000000000e-05 4.265514077601e-09 1.999900000000e-05 4.265514077601e-09 2.000000000000e-05 3.845911471535e-09 2.499900000000e-05 3.845911471535e-09 2.500000000000e-05 4.338014350860e-09 2.999900000000e-05 4.338014350860e-09 3.000000000000e-05 3.986996973671e-09 3.499900000000e-05 3.986996973671e-09 3.500000000000e-05 3.634167671616e-09 3.999900000000e-05 3.634167671616e-09 4.000000000000e-05 4.266820644304e-09 4.499900000000e-05 4.266820644304e-09 4.500000000000e-05 3.847169364714e-09 4.999900000000e-05 3.847169364714e-09 5.000000000000e-05 3.684369121812e-09 5.499900000000e-05 3.684369121812e-09 5.500000000000e-05 4.294980606245e-09 5.999900000000e-05 4.294980606245e-09 6.000000000000e-05 4.003850710681e-09 6.499900000000e-05 4.003850710681e-09 6.500000000000e-05 3.937366908331e-09 6.999900000000e-05 3.937366908331e-09 7.000000000000e-05 4.593536811945e-09 7.499900000000e-05 4.593536811945e-09 7.500000000000e-05 4.248664996318e-09 7.999900000000e-05 4.248664996318e-09 8.000000000000e-05 4.452604102352e-09 8.499900000000e-05 4.452604102352e-09 8.500000000000e-05 4.093421423948e-09 8.999900000000e-05 4.093421423948e-09 9.000000000000e-05 3.065609900956e-09 9.499900000000e-05 3.065609900956e-09 9.500000000000e-05 4.023834790206e-09 9.999900000000e-05 4.023834790206e-09 1.000000000000e-04 4.023834790206e-09 5.000000000000e-01 4.023834790206e-09 ]
