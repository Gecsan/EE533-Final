// 500 ms hold-current Spectre isource PWL for I_NEURON_78_500MS
I_NEURON_78_500MS (iin 0) isource type=pwl wave=[ 0.000000000000e+00 3.972942851501e-09 4.999000000000e-06 3.972942851501e-09 5.000000000000e-06 3.569867426418e-09 9.999000000000e-06 3.569867426418e-09 1.000000000000e-05 4.538868994668e-09 1.499900000000e-05 4.538868994668e-09 1.500000000000e-05 3.964598741982e-09 1.999900000000e-05 3.964598741982e-09 2.000000000000e-05 4.010926068551e-09 2.499900000000e-05 4.010926068551e-09 2.500000000000e-05 3.754855339571e-09 2.999900000000e-05 3.754855339571e-09 3.000000000000e-05 4.103674154954e-09 3.499900000000e-05 4.103674154954e-09 3.500000000000e-05 3.624854848613e-09 3.999900000000e-05 3.624854848613e-09 4.000000000000e-05 3.878368923404e-09 4.499900000000e-05 3.878368923404e-09 4.500000000000e-05 3.768668755506e-09 4.999900000000e-05 3.768668755506e-09 5.000000000000e-05 3.962063932143e-09 5.499900000000e-05 3.962063932143e-09 5.500000000000e-05 4.470546353172e-09 5.999900000000e-05 4.470546353172e-09 6.000000000000e-05 3.902045604516e-09 6.499900000000e-05 3.902045604516e-09 6.500000000000e-05 4.329690517453e-09 6.999900000000e-05 4.329690517453e-09 7.000000000000e-05 4.493257989788e-09 7.499900000000e-05 4.493257989788e-09 7.500000000000e-05 3.893232165872e-09 7.999900000000e-05 3.893232165872e-09 8.000000000000e-05 4.073992223843e-09 8.499900000000e-05 4.073992223843e-09 8.500000000000e-05 4.140264956838e-09 8.999900000000e-05 4.140264956838e-09 9.000000000000e-05 3.762230944102e-09 9.499900000000e-05 3.762230944102e-09 9.500000000000e-05 3.785047693139e-09 9.999900000000e-05 3.785047693139e-09 1.000000000000e-04 3.785047693139e-09 5.000000000000e-01 3.785047693139e-09 ]
